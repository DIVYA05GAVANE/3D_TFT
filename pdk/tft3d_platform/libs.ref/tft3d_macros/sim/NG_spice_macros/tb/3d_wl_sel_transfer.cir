3d wl_sel transfer
.include ../models/lib_3d_tft_macros_clean.spice
.option numdgt=6
.temp 27

VDD vdd 0 2
Va a 0 2
Vsel sel 0 0
X1 a sel y vdd 0 wl_sel
Cout y 0 20f
Rleak y 0 1e9

.dc Vsel -0.5 3.0 0.005
.print dc v(sel) v(y)
.control
run
set filetype=ascii
set wr_singlescale
set wr_vecnames
wrdata ../results/3d_wl_sel_transfer.dat v(sel) v(y)
write ../results/3d_wl_sel_transfer.raw
.endc
.end
