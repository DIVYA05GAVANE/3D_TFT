column_decoder_3to8_nmos transient address sweep
.include ../models/lib_main_clean.spice
.option numdgt=6
.temp 27

VDD vdd 0 2
VDDA vdda 0 3
Vc0 c0 0 PULSE(0 2 0 5n 5n 0.5u 1u)
Vc1 c1 0 PULSE(0 2 0 5n 5n 1u 2u)
Vc2 c2 0 PULSE(0 2 0 5n 5n 2u 4u)
X1 a1 a2 a3 c0 c1 c2 col0 col1 col2 col3 col4 col5 col6 col7 nand_1 nand_2 vdd vdda 0 0 column_decoder_3to8_nmos
Ccol0 col0 0 20f
Rcol0 col0 0 1e9
Ccol1 col1 0 20f
Rcol1 col1 0 1e9
Ccol2 col2 0 20f
Rcol2 col2 0 1e9
Ccol3 col3 0 20f
Rcol3 col3 0 1e9
Ccol4 col4 0 20f
Rcol4 col4 0 1e9
Ccol5 col5 0 20f
Rcol5 col5 0 1e9
Ccol6 col6 0 20f
Rcol6 col6 0 1e9
Ccol7 col7 0 20f
Rcol7 col7 0 1e9
Rn1 nand_1 0 1e9
Rn2 nand_2 0 1e9

.tran 10n 8u
.print tran v(col0)
.control
run
set filetype=ascii
set wr_singlescale
set wr_vecnames
wrdata ../results/column_decoder_3to8_tran.dat v(c0) v(c1) v(c2) v(col0) v(col1) v(col2) v(col3) v(col4) v(col5) v(col6) v(col7)
write ../results/column_decoder_3to8_tran.raw
.endc
.end
