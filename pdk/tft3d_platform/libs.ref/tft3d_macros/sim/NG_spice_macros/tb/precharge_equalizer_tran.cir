precharge_equalizer_nmos_6u transient
.include ../models/lib_main_clean.spice
.option numdgt=6
.temp 27

X1 bl blb eq pchg vdd vpre precharge_equalizer_nmos_6u
Cbl bl 0 200p ic=0
Cblb blb 0 100p ic=0
Rbl bl 0 100k
Rblb blb 0 50k
Vpchg pchg 0 PULSE(3 0 0 100n 100n 10u 20u)
Veq eq 0 PULSE(0 3 0 100n 100n 10u 20u)
Vvdd vdd 0 2
Vvpre vpre 0 3.5

.tran 20n 50u uic
.print tran v(bl)
.control
run
set filetype=ascii
set wr_singlescale
set wr_vecnames
let veq_out = v(eq)
let vpchg_out = v(pchg)
let vbl_out = v(bl)
let vblb_out = v(blb)
wrdata ../results/precharge_equalizer_tran.dat veq_out vpchg_out vbl_out vblb_out
write ../results/precharge_equalizer_tran.raw
.endc
.end
