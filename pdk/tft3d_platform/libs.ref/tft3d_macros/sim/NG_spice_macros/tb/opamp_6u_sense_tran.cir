opamp_6u sense transient
.include ../models/lib_main_clean.spice
.option numdgt=6
.temp 27

X1 out sl slb vdd vdd_inv 0 vth opamp_6u
Islb 0 slb PULSE(70u 40u 0 100n 100n 10u 20u)
Isl 0 sl PULSE(40u 70u 0 100n 100n 10u 20u)
Vvdd vdd 0 2.5
Vvddi vdd_inv 0 2
Vvth vth 0 1
Cout out 0 1p
Rout out 0 1e9

.tran 20n 40u
.print tran v(out)
.control
run
set filetype=ascii
set wr_singlescale
set wr_vecnames
wrdata ../results/opamp_6u_sense_tran.dat v(out) v(sl) v(slb) v(vth)
write ../results/opamp_6u_sense_tran.raw
.endc
.end
