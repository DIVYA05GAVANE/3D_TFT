analog_mux_2to1_diff_nmos_schematic transient
.include ../models/lib_main_clean.spice
.option numdgt=6
.temp 27

Vbl0 bl0 0 3
Vblb0 blb0 0 -3
Vpre pre 0 2
Vpreb pre_b 0 2
Vsel sel 0 PULSE(-2 2 0.5u 20n 20n 1.0u 2.0u)
Vselb selb 0 PULSE(2 -2 0.5u 20n 20n 1.0u 2.0u)
X1 bl0 blb0 gbl gblb pre pre_b sel selb analog_mux_2to1_diff_nmos_schematic
Cgbl gbl 0 1p
Cgblb gblb 0 1p
Rgbl gbl 0 20k
Rgblb gblb 0 20k

.tran 10n 5u
.print tran v(gbl)
.control
run
set filetype=ascii
set wr_singlescale
set wr_vecnames
wrdata ../results/analog_mux_2to1_diff_schematic_tran.dat v(sel) v(selb) v(bl0) v(blb0) v(gbl) v(gblb)
write ../results/analog_mux_2to1_diff_schematic_tran.raw
.endc
.end
