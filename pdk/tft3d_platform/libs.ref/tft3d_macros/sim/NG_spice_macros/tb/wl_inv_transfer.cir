wl_inv transfer
.include ../models/lib_main_clean.spice
.option numdgt=6
.temp 27

VDD vdd 0 2
Vin wl_en 0 0
X1 vdd 0 wl_en wl_enb wl_inv
Cout wl_enb 0 20f
Rleak wl_enb 0 1e9

.dc Vin -0.5 3.0 0.005
.print dc v(wl_en) v(wl_enb)
.control
run
set filetype=ascii
set wr_singlescale
set wr_vecnames
wrdata ../results/wl_inv_transfer.dat v(wl_en) v(wl_enb)
write ../results/wl_inv_transfer.raw
.endc
.end
