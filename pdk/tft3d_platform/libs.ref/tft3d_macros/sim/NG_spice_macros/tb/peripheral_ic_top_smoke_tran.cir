Peripheral_IC top-level smoke transient
.include ../models/lib_main_clean.spice
.option numdgt=6
.temp 27
Vvddwl vdd_driver_wl 0 2
Vvsswl vss_driver_wl 0 0
Vvwlp vwl_p_wl_driver 0 3
Vvwln vwl_n_wl_driver 0 0
Vvdddecwl vdd_decoder_wl 0 2
Vvddadecwl vdda_decoder_wl 0 3
Vvssdecwl vss_decoder_wl 0 0
Vvssadecwl vssa_decoder_wl 0 0
Vvddcoldec vdd_column_decoder 0 2
Vvddacoldec vdda_column_decoder 0 3
Vvsscoldec vss_column_decoder 0 0
Vvssacoldec vssa_column_decoder 0 0
Vvddcoldrv vdd_column_driver 0 1.5
Vvddacoldrv vdda_column_driver 0 2
Vvphbbl vphb_bl_column_driver 0 3
Vvphbsl vphb_sl_column_driver 0 2
Vvphbl vph_bl_column_driver 0 3
Vvphsl vph_sl_column_driver 0 2
Vvplbbl vplb_bl_column_decoder 0 0
Vvplbsl vplb_sl_column_decoder 0 0
Vvplbl vpl_bl_column_decoder 0 0
Vvplsl vpl_sl_column_decoder 0 0
Vprecharge precharge 0 2
Vvpre vpre 0 3.5
Veq eq 0 PULSE(0 3 0 50n 50n 1u 2u)
Vpchg pchg 0 PULSE(3 0 0 50n 50n 1u 2u)
Vselmux sel_mux 0 PULSE(-2 2 0.2u 20n 20n 0.8u 1.6u)
Vselbmux selb_mux 0 PULSE(2 -2 0.2u 20n 20n 0.8u 1.6u)
Vwe we 0 1.2
Vwlin wl_in 0 PULSE(0 1.2 0 20n 20n 0.8u 1.6u)
Vvddsense vdd_sense 0 2.5
Vvddinvsense vdd_inv_sense 0 2
Vvsssense vss_sense 0 0
Vvthsense vth_sense 0 1
Vdin net097 0 PULSE(0 1.2 0.4u 20n 20n 0.8u 1.6u)
Vco co 0 PULSE(0 2 0 10n 10n 0.4u 0.8u)
Vc1 c1 0 PULSE(0 2 0 10n 10n 0.8u 1.6u)
Vc2 c2 0 PULSE(0 2 0 10n 10n 1.6u 3.2u)
Vd0 d0 0 PULSE(0 2 0 10n 10n 0.4u 0.8u)
Vd1 d1 0 PULSE(0 2 0 10n 10n 0.8u 1.6u)
Vd2 d2 0 PULSE(0 2 0 10n 10n 1.6u 3.2u)
Vd3 d3 0 PULSE(0 2 0 10n 10n 0.4u 0.8u)
Vd4 d4 0 PULSE(0 2 0 10n 10n 0.8u 1.6u)
Vd5 d5 0 PULSE(0 2 0 10n 10n 1.6u 3.2u)
Vd6 d6 0 PULSE(0 2 0 10n 10n 0.4u 0.8u)
Vd7 d7 0 PULSE(0 2 0 10n 10n 0.8u 1.6u)
Vd8 d8 0 PULSE(0 2 0 10n 10n 1.6u 3.2u)
Vd9 d9 0 PULSE(0 2 0 10n 10n 0.4u 0.8u)
Vd10 d10 0 PULSE(0 2 0 10n 10n 0.8u 1.6u)
Vd11 d11 0 PULSE(0 2 0 10n 10n 1.6u 3.2u)

Rwlout0 wl_out<0> 0 1e9
Cwlout0 wl_out<0> 0 20f
Rwlout1 wl_out<1> 0 1e9
Cwlout1 wl_out<1> 0 20f
Rwlout2 wl_out<2> 0 1e9
Cwlout2 wl_out<2> 0 20f
Rwlout3 wl_out<3> 0 1e9
Cwlout3 wl_out<3> 0 20f
Rwlout4 wl_out<4> 0 1e9
Cwlout4 wl_out<4> 0 20f
Rwlout5 wl_out<5> 0 1e9
Cwlout5 wl_out<5> 0 20f
Rwlout6 wl_out<6> 0 1e9
Cwlout6 wl_out<6> 0 20f
Rwlout7 wl_out<7> 0 1e9
Cwlout7 wl_out<7> 0 20f
Rwlout8 wl_out<8> 0 1e9
Cwlout8 wl_out<8> 0 20f
Rwlout9 wl_out<9> 0 1e9
Cwlout9 wl_out<9> 0 20f
Rwlout10 wl_out<10> 0 1e9
Cwlout10 wl_out<10> 0 20f
Rwlout11 wl_out<11> 0 1e9
Cwlout11 wl_out<11> 0 20f
Rwlout12 wl_out<12> 0 1e9
Cwlout12 wl_out<12> 0 20f
Rwlout13 wl_out<13> 0 1e9
Cwlout13 wl_out<13> 0 20f
Rwlout14 wl_out<14> 0 1e9
Cwlout14 wl_out<14> 0 20f
Rwlout15 wl_out<15> 0 1e9
Cwlout15 wl_out<15> 0 20f
Rwlout16 wl_out<16> 0 1e9
Cwlout16 wl_out<16> 0 20f
Rwlout17 wl_out<17> 0 1e9
Cwlout17 wl_out<17> 0 20f
Rwlout18 wl_out<18> 0 1e9
Cwlout18 wl_out<18> 0 20f
Rwlout19 wl_out<19> 0 1e9
Cwlout19 wl_out<19> 0 20f
Rwlout20 wl_out<20> 0 1e9
Cwlout20 wl_out<20> 0 20f
Rwlout21 wl_out<21> 0 1e9
Cwlout21 wl_out<21> 0 20f
Rwlout22 wl_out<22> 0 1e9
Cwlout22 wl_out<22> 0 20f
Rwlout23 wl_out<23> 0 1e9
Cwlout23 wl_out<23> 0 20f
Rwlout24 wl_out<24> 0 1e9
Cwlout24 wl_out<24> 0 20f
Rwlout25 wl_out<25> 0 1e9
Cwlout25 wl_out<25> 0 20f
Rwlout26 wl_out<26> 0 1e9
Cwlout26 wl_out<26> 0 20f
Rwlout27 wl_out<27> 0 1e9
Cwlout27 wl_out<27> 0 20f
Rwlout28 wl_out<28> 0 1e9
Cwlout28 wl_out<28> 0 20f
Rwlout29 wl_out<29> 0 1e9
Cwlout29 wl_out<29> 0 20f
Rwlout30 wl_out<30> 0 1e9
Cwlout30 wl_out<30> 0 20f
Rwlout31 wl_out<31> 0 1e9
Cwlout31 wl_out<31> 0 20f
R_bl_0 bl<0> 0 1e9
R_blb_0 blb<0> 0 1e9
R_sl_0 sl<0> 0 1e9
R_slb_0 slb<0> 0 1e9
R_array_bl_0 array_bl<0> 0 1e9
R_array_blb_0 array_blb<0> 0 1e9
R_array_sl_0 array_sl<0> 0 1e9
R_array_slb_0 array_slb<0> 0 1e9
R_p_bl_0 p_bl<0> 0 1e9
R_p_blb_0 p_blb<0> 0 1e9
R_sen_bl_0 sen_bl<0> 0 1e9
R_sen_blb_0 sen_blb<0> 0 1e9
R_sense_out_0 sense_out<0> 0 1e9
R_col_0 col<0> 0 1e9
C_bl_0 bl<0> 0 20f
C_blb_0 blb<0> 0 20f
C_sl_0 sl<0> 0 20f
C_slb_0 slb<0> 0 20f
C_array_bl_0 array_bl<0> 0 20f
C_array_blb_0 array_blb<0> 0 20f
C_array_sl_0 array_sl<0> 0 20f
C_array_slb_0 array_slb<0> 0 20f
C_p_bl_0 p_bl<0> 0 20f
C_p_blb_0 p_blb<0> 0 20f
C_sen_bl_0 sen_bl<0> 0 20f
C_sen_blb_0 sen_blb<0> 0 20f
C_sense_out_0 sense_out<0> 0 20f
R_bl_1 bl<1> 0 1e9
R_blb_1 blb<1> 0 1e9
R_sl_1 sl<1> 0 1e9
R_slb_1 slb<1> 0 1e9
R_array_bl_1 array_bl<1> 0 1e9
R_array_blb_1 array_blb<1> 0 1e9
R_array_sl_1 array_sl<1> 0 1e9
R_array_slb_1 array_slb<1> 0 1e9
R_p_bl_1 p_bl<1> 0 1e9
R_p_blb_1 p_blb<1> 0 1e9
R_sen_bl_1 sen_bl<1> 0 1e9
R_sen_blb_1 sen_blb<1> 0 1e9
R_sense_out_1 sense_out<1> 0 1e9
R_col_1 col<1> 0 1e9
C_bl_1 bl<1> 0 20f
C_blb_1 blb<1> 0 20f
C_sl_1 sl<1> 0 20f
C_slb_1 slb<1> 0 20f
C_array_bl_1 array_bl<1> 0 20f
C_array_blb_1 array_blb<1> 0 20f
C_array_sl_1 array_sl<1> 0 20f
C_array_slb_1 array_slb<1> 0 20f
C_p_bl_1 p_bl<1> 0 20f
C_p_blb_1 p_blb<1> 0 20f
C_sen_bl_1 sen_bl<1> 0 20f
C_sen_blb_1 sen_blb<1> 0 20f
C_sense_out_1 sense_out<1> 0 20f
R_bl_2 bl<2> 0 1e9
R_blb_2 blb<2> 0 1e9
R_sl_2 sl<2> 0 1e9
R_slb_2 slb<2> 0 1e9
R_array_bl_2 array_bl<2> 0 1e9
R_array_blb_2 array_blb<2> 0 1e9
R_array_sl_2 array_sl<2> 0 1e9
R_array_slb_2 array_slb<2> 0 1e9
R_p_bl_2 p_bl<2> 0 1e9
R_p_blb_2 p_blb<2> 0 1e9
R_sen_bl_2 sen_bl<2> 0 1e9
R_sen_blb_2 sen_blb<2> 0 1e9
R_sense_out_2 sense_out<2> 0 1e9
R_col_2 col<2> 0 1e9
C_bl_2 bl<2> 0 20f
C_blb_2 blb<2> 0 20f
C_sl_2 sl<2> 0 20f
C_slb_2 slb<2> 0 20f
C_array_bl_2 array_bl<2> 0 20f
C_array_blb_2 array_blb<2> 0 20f
C_array_sl_2 array_sl<2> 0 20f
C_array_slb_2 array_slb<2> 0 20f
C_p_bl_2 p_bl<2> 0 20f
C_p_blb_2 p_blb<2> 0 20f
C_sen_bl_2 sen_bl<2> 0 20f
C_sen_blb_2 sen_blb<2> 0 20f
C_sense_out_2 sense_out<2> 0 20f
R_bl_3 bl<3> 0 1e9
R_blb_3 blb<3> 0 1e9
R_sl_3 sl<3> 0 1e9
R_slb_3 slb<3> 0 1e9
R_array_bl_3 array_bl<3> 0 1e9
R_array_blb_3 array_blb<3> 0 1e9
R_array_sl_3 array_sl<3> 0 1e9
R_array_slb_3 array_slb<3> 0 1e9
R_p_bl_3 p_bl<3> 0 1e9
R_p_blb_3 p_blb<3> 0 1e9
R_sen_bl_3 sen_bl<3> 0 1e9
R_sen_blb_3 sen_blb<3> 0 1e9
R_sense_out_3 sense_out<3> 0 1e9
R_col_3 col<3> 0 1e9
C_bl_3 bl<3> 0 20f
C_blb_3 blb<3> 0 20f
C_sl_3 sl<3> 0 20f
C_slb_3 slb<3> 0 20f
C_array_bl_3 array_bl<3> 0 20f
C_array_blb_3 array_blb<3> 0 20f
C_array_sl_3 array_sl<3> 0 20f
C_array_slb_3 array_slb<3> 0 20f
C_p_bl_3 p_bl<3> 0 20f
C_p_blb_3 p_blb<3> 0 20f
C_sen_bl_3 sen_bl<3> 0 20f
C_sen_blb_3 sen_blb<3> 0 20f
C_sense_out_3 sense_out<3> 0 20f
R_bl_4 bl<4> 0 1e9
R_blb_4 blb<4> 0 1e9
R_sl_4 sl<4> 0 1e9
R_slb_4 slb<4> 0 1e9
R_array_bl_4 array_bl<4> 0 1e9
R_array_blb_4 array_blb<4> 0 1e9
R_array_sl_4 array_sl<4> 0 1e9
R_array_slb_4 array_slb<4> 0 1e9
R_p_bl_4 p_bl<4> 0 1e9
R_p_blb_4 p_blb<4> 0 1e9
R_sen_bl_4 sen_bl<4> 0 1e9
R_sen_blb_4 sen_blb<4> 0 1e9
R_sense_out_4 sense_out<4> 0 1e9
R_col_4 col<4> 0 1e9
C_bl_4 bl<4> 0 20f
C_blb_4 blb<4> 0 20f
C_sl_4 sl<4> 0 20f
C_slb_4 slb<4> 0 20f
C_array_bl_4 array_bl<4> 0 20f
C_array_blb_4 array_blb<4> 0 20f
C_array_sl_4 array_sl<4> 0 20f
C_array_slb_4 array_slb<4> 0 20f
C_p_bl_4 p_bl<4> 0 20f
C_p_blb_4 p_blb<4> 0 20f
C_sen_bl_4 sen_bl<4> 0 20f
C_sen_blb_4 sen_blb<4> 0 20f
C_sense_out_4 sense_out<4> 0 20f
R_bl_5 bl<5> 0 1e9
R_blb_5 blb<5> 0 1e9
R_sl_5 sl<5> 0 1e9
R_slb_5 slb<5> 0 1e9
R_array_bl_5 array_bl<5> 0 1e9
R_array_blb_5 array_blb<5> 0 1e9
R_array_sl_5 array_sl<5> 0 1e9
R_array_slb_5 array_slb<5> 0 1e9
R_p_bl_5 p_bl<5> 0 1e9
R_p_blb_5 p_blb<5> 0 1e9
R_sen_bl_5 sen_bl<5> 0 1e9
R_sen_blb_5 sen_blb<5> 0 1e9
R_sense_out_5 sense_out<5> 0 1e9
R_col_5 col<5> 0 1e9
C_bl_5 bl<5> 0 20f
C_blb_5 blb<5> 0 20f
C_sl_5 sl<5> 0 20f
C_slb_5 slb<5> 0 20f
C_array_bl_5 array_bl<5> 0 20f
C_array_blb_5 array_blb<5> 0 20f
C_array_sl_5 array_sl<5> 0 20f
C_array_slb_5 array_slb<5> 0 20f
C_p_bl_5 p_bl<5> 0 20f
C_p_blb_5 p_blb<5> 0 20f
C_sen_bl_5 sen_bl<5> 0 20f
C_sen_blb_5 sen_blb<5> 0 20f
C_sense_out_5 sense_out<5> 0 20f
R_bl_6 bl<6> 0 1e9
R_blb_6 blb<6> 0 1e9
R_sl_6 sl<6> 0 1e9
R_slb_6 slb<6> 0 1e9
R_array_bl_6 array_bl<6> 0 1e9
R_array_blb_6 array_blb<6> 0 1e9
R_array_sl_6 array_sl<6> 0 1e9
R_array_slb_6 array_slb<6> 0 1e9
R_p_bl_6 p_bl<6> 0 1e9
R_p_blb_6 p_blb<6> 0 1e9
R_sen_bl_6 sen_bl<6> 0 1e9
R_sen_blb_6 sen_blb<6> 0 1e9
R_sense_out_6 sense_out<6> 0 1e9
R_col_6 col<6> 0 1e9
C_bl_6 bl<6> 0 20f
C_blb_6 blb<6> 0 20f
C_sl_6 sl<6> 0 20f
C_slb_6 slb<6> 0 20f
C_array_bl_6 array_bl<6> 0 20f
C_array_blb_6 array_blb<6> 0 20f
C_array_sl_6 array_sl<6> 0 20f
C_array_slb_6 array_slb<6> 0 20f
C_p_bl_6 p_bl<6> 0 20f
C_p_blb_6 p_blb<6> 0 20f
C_sen_bl_6 sen_bl<6> 0 20f
C_sen_blb_6 sen_blb<6> 0 20f
C_sense_out_6 sense_out<6> 0 20f
R_bl_7 bl<7> 0 1e9
R_blb_7 blb<7> 0 1e9
R_sl_7 sl<7> 0 1e9
R_slb_7 slb<7> 0 1e9
R_array_bl_7 array_bl<7> 0 1e9
R_array_blb_7 array_blb<7> 0 1e9
R_array_sl_7 array_sl<7> 0 1e9
R_array_slb_7 array_slb<7> 0 1e9
R_p_bl_7 p_bl<7> 0 1e9
R_p_blb_7 p_blb<7> 0 1e9
R_sen_bl_7 sen_bl<7> 0 1e9
R_sen_blb_7 sen_blb<7> 0 1e9
R_sense_out_7 sense_out<7> 0 1e9
R_col_7 col<7> 0 1e9
C_bl_7 bl<7> 0 20f
C_blb_7 blb<7> 0 20f
C_sl_7 sl<7> 0 20f
C_slb_7 slb<7> 0 20f
C_array_bl_7 array_bl<7> 0 20f
C_array_blb_7 array_blb<7> 0 20f
C_array_sl_7 array_sl<7> 0 20f
C_array_slb_7 array_slb<7> 0 20f
C_p_bl_7 p_bl<7> 0 20f
C_p_blb_7 p_blb<7> 0 20f
C_sen_bl_7 sen_bl<7> 0 20f
C_sen_blb_7 sen_blb<7> 0 20f
C_sense_out_7 sense_out<7> 0 20f

.tran 20n 4u
.print tran v(wl_out<0>)
.control
run
set filetype=ascii
set wr_singlescale
set wr_vecnames
let wlout0 = v(wl_out<0>)
let col0v = v(col<0>)
let bl0v = v(bl<0>)
let sense0v = v(sense_out<0>)
wrdata ../results/peripheral_ic_top_smoke_tran.dat wlout0 col0v bl0v sense0v
write ../results/peripheral_ic_top_smoke_tran.raw
.endc
.end
