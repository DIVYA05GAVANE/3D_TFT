row_decoder_3to8_nmos transient address sweep
.include ../models/lib_main_clean.spice
.option numdgt=6
.temp 27

VDD vdd 0 2
VDDA vdda 0 3
Vd0 d0 0 PULSE(0 2 0 5n 5n 0.5u 1u)
Vd1 d1 0 PULSE(0 2 0 5n 5n 1u 2u)
Vd2 d2 0 PULSE(0 2 0 5n 5n 2u 4u)
X1 a1 a2 a3 d0 d1 d2 nand_1 nand_2 q0 q1 q2 q3 q4 q5 q6 q7 vdd vdda 0 0 row_decoder_3to8_nmos
Cq0 q0 0 20f
Rq0 q0 0 1e9
Cq1 q1 0 20f
Rq1 q1 0 1e9
Cq2 q2 0 20f
Rq2 q2 0 1e9
Cq3 q3 0 20f
Rq3 q3 0 1e9
Cq4 q4 0 20f
Rq4 q4 0 1e9
Cq5 q5 0 20f
Rq5 q5 0 1e9
Cq6 q6 0 20f
Rq6 q6 0 1e9
Cq7 q7 0 20f
Rq7 q7 0 1e9
Rn1 nand_1 0 1e9
Rn2 nand_2 0 1e9

.tran 10n 8u
.print tran v(q0)
.control
run
set filetype=ascii
set wr_singlescale
set wr_vecnames
wrdata ../results/row_decoder_3to8_tran.dat v(d0) v(d1) v(d2) v(q0) v(q1) v(q2) v(q3) v(q4) v(q5) v(q6) v(q7)
write ../results/row_decoder_3to8_tran.raw
.endc
.end
