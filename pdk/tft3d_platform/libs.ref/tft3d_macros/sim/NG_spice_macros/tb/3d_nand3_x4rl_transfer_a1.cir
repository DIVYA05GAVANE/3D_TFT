3d NAND3_X4RL_T5 transfer
.include ../models/lib_3d_tft_macros_clean.spice
.option numdgt=6
.temp 27

VDD vdd 0 2
Va1 a1 0 0
Va2 a2 0 2
Va3 a3 0 2
X1 a1 a2 a3 vdd 0 y NAND3_X4RL_T5
Cout y 0 20f
Rleak y 0 1e9

.dc Va1 -0.5 3.0 0.005
.print dc v(a1) v(y)
.control
run
set filetype=ascii
set wr_singlescale
set wr_vecnames
wrdata ../results/3d_nand3_x4rl_transfer_a1.dat v(a1) v(y)
write ../results/3d_nand3_x4rl_transfer_a1.raw
.endc
.end
