wl_sel transient
.include ../models/lib_main_clean.spice
.option numdgt=6
.temp 27

Vvwp vwl_p 0 3
Vvwn vwl_n 0 0
Ven wl_en 0 PULSE(0 2 0 5n 5n 0.5u 1u)
Venb wl_enb 0 PULSE(2 0 0 5n 5n 0.5u 1u)
X1 s1 s2 s3 vwl_n vwl_p wl_en wl_enb wl_out wl_sel
Cout wl_out 0 30f
Rleak1 s1 0 1e9
Rleak2 s2 0 1e9
Rleak3 s3 0 1e9
Rleak4 wl_out 0 1e9

.tran 5n 3u
.print tran v(wl_out)
.control
run
set filetype=ascii
set wr_singlescale
set wr_vecnames
wrdata ../results/wl_sel_tran.dat v(wl_en) v(wl_enb) v(s1) v(s2) v(s3) v(wl_out)
write ../results/wl_sel_tran.raw
.endc
.end
