nand3_x4rl_t5 DC transfer with A2=A3=2V
.include ../models/lib_main_clean.spice
.option numdgt=6
.temp 27

VDD vdd 0 2
Va1 a1 0 0
Va2 a2 0 2
Va3 a3 0 2
X1 a1 a2 a3 vdd 0 y nand3_x4rl_t5
Cout y 0 20f
Rleak y 0 1e9

.dc Va1 -0.5 3.0 0.005
.print dc v(a1) v(y)
.control
run
set filetype=ascii
set wr_singlescale
set wr_vecnames
wrdata ../results/nand3_x4rl_transfer_a1.dat v(a1) v(y)
write ../results/nand3_x4rl_transfer_a1.raw
.endc
.end
