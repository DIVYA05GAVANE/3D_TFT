* Basic SPICE placeholders for the imported 3D_TFT hard macros.
* Include pdk/tft3d_platform/libs.tech/ngspice/tft3d_platform_primitives.spice
* or pdk/tft3d_platform/libs.tech/ngspice/tft3d_platform.spice before this file.
* These models are for flow bring-up and functional checks only.

.subckt nfet_W20p825_L5 D G S VSS
M0 D G S VSS nch W=20.825u L=5u M=1
.ends nfet_W20p825_L5

.subckt nfet_W24u_L5 D G S VSS
M0 D G S VSS nch W=24u L=5u M=1
.ends nfet_W24u_L5

.subckt nfet_W6u_L5 D G S VSS
M0 D G S VSS nch W=6u L=5u M=1
.ends nfet_W6u_L5

.subckt NAND3_X4RL_T5 A1 A2 A3 VDD VSS Y
XN0 net011 A3 VSS VSS nfet_W24u_L5
XN1 net016 A2 net011 net011 nfet_W24u_L5
XN2 Y A1 net016 net016 nfet_W24u_L5
XPU VDD VDD Y Y nfet_W6u_L5
.ends NAND3_X4RL_T5

.subckt INV_X4PC_T5_nmos A Y VDD VSS
RPU VDD Y 24k
M0 Y A VSS VSS nch W=24u L=5u M=4
COUT Y VSS 10f
.ends INV_X4PC_T5_nmos

.subckt wl_inv A Y VDD VSS
XINV A Y VDD VSS INV_X4PC_T5_nmos
.ends wl_inv

.subckt wl_prebuffer A Y VDD VSS
XINV0 A mid VDD VSS INV_X4PC_T5_nmos
XINV1 mid Y VDD VSS INV_X4PC_T5_nmos
.ends wl_prebuffer

.subckt wl_sel A SEL Y VDD VSS
RPU VDD Y 24k
MSEL Y SEL mid VSS nch W=6u L=5u M=1
MDAT mid A VSS VSS nch W=6u L=5u M=1
COUT Y VSS 10f
.ends wl_sel

* Physical-only SRAM array flavour placeholders extracted from
* Stack_SRAM_260605_F.gds.  F5 carries the explicit peripheral_ic array
* interface: top BL/BLB pairs, bottom SL/SLB pairs, and left/right WL pins.
.subckt stack_sram_array_f0
.ends stack_sram_array_f0

.subckt stack_sram_array_f1
.ends stack_sram_array_f1

.subckt stack_sram_array_f2
.ends stack_sram_array_f2

.subckt stack_sram_array_f3
.ends stack_sram_array_f3

.subckt stack_sram_array_f4
.ends stack_sram_array_f4

.subckt stack_sram_array_f5 bl<0> bl<1> bl<2> bl<3> bl<4> bl<5> bl<6> bl<7> blb<0> blb<1> blb<2> blb<3> blb<4> blb<5> blb<6> blb<7> sl<0> sl<1> sl<2> sl<3> sl<4> sl<5> sl<6> sl<7> slb<0> slb<1> slb<2> slb<3> slb<4> slb<5> slb<6> slb<7> wl<0> wl<1> wl<2> wl<3> wl<4> wl<5> wl<6> wl<7> wl<8> wl<9> wl<10> wl<11> wl<12> wl<13> wl<14> wl<15> wl<16> wl<17> wl<18> wl<19> wl<20> wl<21> wl<22> wl<23> wl<24> wl<25> wl<26> wl<27> wl<28> wl<29> wl<30> wl<31>
.ends stack_sram_array_f5
