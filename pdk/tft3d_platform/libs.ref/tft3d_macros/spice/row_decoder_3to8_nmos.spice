*  Generated for: HSPICE
*  Generated on: Jun 12 02:09:13 2026
*  Design library name: CAM_Circuits
*  Design cell name: tb_row_decoder_3to8_aloneQ0
*  Design view name: schematic
.include '/apps/PDK/NCSU/FreePDK/FreePDK45/1.4/ncsu_basekit/models/hspice/hspice_nom.include'
*  Library name: CAM_Circuits
*  Cell name: nfet_W24u_L5
*  View name: schematic
.subckt nfet_w24u_l5 d g s
+   l=5e-6 w=24e-6 m=1
    m0 d g s s NMOS_VTG L=l W=w AD=2.52e-12 AS=2.52e-12 PD=24.21e-6 PS=24.21e-6 M=m
.ends
*  End of subcircuit definition.
*  Library name: CAM_Circuits
*  Cell name: nfet_W20p825_L5
*  View name: schematic
.subckt nfet_w20p825_l5 d g s
+   l=5e-6 w=20.825e-6 m=1
    m0 d g s s NMOS_VTG L=l W=w AD=2.18663e-12 AS=2.18663e-12 PD=21.035e-6 PS=21.035e-6 M=m
.ends
*  End of subcircuit definition.
*  Library name: CAM_Circuits
*  Cell name: INV_X4PC_T5_nmos
*  View name: schematic
.subckt inv_x4pc_t5_nmos in out vdd vss
    xi10 vdd vdd an nfet_w24u_l5 m=1 l=5e-6 w=24e-6 m=1
    xi6 an in vss nfet_w20p825_l5 m=4 l=5e-6 w=20.825e-6 m=4
    xi8 out in vss nfet_w20p825_l5 m=8 l=5e-6 w=20.825e-6 m=8
    xi7 vdd an out nfet_w20p825_l5 m=8 l=5e-6 w=20.825e-6 m=8
.ends
*  End of subcircuit definition.
*  Library name: CAM_Circuits
*  Cell name: nfet_W6u_L5
*  View name: schematic
.subckt nfet_w6u_l5 d g s
    m0 d g s s NMOS_VTG L=5e-6 W=6e-6 AD=630e-15 AS=630e-15 PD=6.21e-6 PS=6.21e-6 M=1
.ends
*  End of subcircuit definition.
*  Library name: CAM_Circuits
*  Cell name: NAND3_X4RL_T5
*  View name: schematic
.subckt nand3_x4rl_t5 a1 a2 a3 vdd vss y
    xi42 net011 a3 vss nfet_w24u_l5 m=1 l=5e-6 w=24e-6 m=1
    xi41 net016 a2 net011 nfet_w24u_l5 m=1 l=5e-6 w=24e-6 m=1
    xi33 y a1 net016 nfet_w24u_l5 m=1 l=5e-6 w=24e-6 m=1
    xi40 vdd vdd y nfet_w6u_l5
.ends
*  End of subcircuit definition.
*  Library name: CAM_Circuits
*  Cell name: row_decoder_3to8_nmos
*  View name: schematic
.subckt row_decoder_3to8_nmos a1 a2 a3 d0 d1 d2 nand_1 nand_2 q0 q1 q2 q3 q4 q5 q6 q7 vdd vdda vss vssa
    xi106 net025 q7 vdda vssa inv_x4pc_t5_nmos
    xi103 net020 q4 vdda vssa inv_x4pc_t5_nmos
    xi104 net023 q5 vdda vssa inv_x4pc_t5_nmos
    xi105 net021 q6 vdda vssa inv_x4pc_t5_nmos
    xi102 net019 q3 vdda vssa inv_x4pc_t5_nmos
    xi101 net022 q2 vdda vssa inv_x4pc_t5_nmos
    xi100 nand_2 q1 vdda vssa inv_x4pc_t5_nmos
    xi99 nand_1 q0 vdda vssa inv_x4pc_t5_nmos
    xi107 d0 a1 vdd vss inv_x4pc_t5_nmos
    xi108 d1 a2 vdd vss inv_x4pc_t5_nmos
    xi109 d2 a3 vdd vss inv_x4pc_t5_nmos
    xi80 a1 a2 d2 vdd vss nand_2 nand3_x4rl_t5
    xi84 d0 a2 d2 vdd vss net023 nand3_x4rl_t5
    xi87 a1 a2 a3 vdd vss nand_1 nand3_x4rl_t5
    xi83 d0 a2 a3 vdd vss net020 nand3_x4rl_t5
    xi86 d0 d1 a3 vdd vss net021 nand3_x4rl_t5
    xi81 a1 d1 a3 vdd vss net022 nand3_x4rl_t5
    xi82 a1 d1 d2 vdd vss net019 nand3_x4rl_t5
    xi85 d0 d1 d2 vdd vss net025 nand3_x4rl_t5
.ends
*  End of subcircuit definition.

*  Library name: CAM_Circuits
*  Cell name: tb_row_decoder_3to8_aloneQ0
*  View name: schematic
xi26 a2 a3 nand_1 d0 d1 d2 nand_2 net016 out0 out1 out2 out3 out4 out5 out6 out7 net07 net017 0 net015 row_decoder_3to8_nmos
v7 net015 0 dc=0
v5 net017 0 dc=3
v4 d2 0 dc=0
v3 d1 0 dc=0
v2 d0 0 dc=0
v1 net07 0 dc=2
.param
+   Cload=100e-15
.temp 27.0
.option GEN_CUR_POL=ON
.option ARTIST=2 PSF=2 WARN_SEP=1
.option VECBUS=1 LIS_NEW=1 CONVERGE=100
.tran 20e-9 20e-6 start=0.0
.option hier_delim=1
.probe tran v(a1)
+       v(a2)
+       v(a3)
+       v(d0)
+       v(d1)
+       v(d2)
+       v(nand_1)
+       v(nand_2)
+       v(out0)
+       v(out1)
+       v(out2)
+       v(out3)
+       v(out4)
+       v(out5)
+       v(out6)
+       v(out7)
.end
